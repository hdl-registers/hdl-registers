
addrmap atxmega_spi {
    name = "ATXMEGA SPI controller";

    default regwidth = 32;
    default sw = rw;
    default hw = r;

    reg {
        name = "Control Register";

        field {
            desc = "Controls the SPI clock rate when configured in master mode";
        } PRESCALER[1:0] = 0;

        field {
            desc = "These bits select the transfer mode";
        } MODE[3:2] = 0;

        field {
            desc = "Selects master mode when written to one, and slave mode when
            written to zero. If SS is configured as an input and driven low while
            master mode is set, master mode will be cleared";

            hw=rw; we;
        } MASTER[4:4] = 0;

        field {
            desc = "DORD decides the data order when a byte is shifted out from
            the DATA register. When DORD is written to one, the least-significant
            bit (lsb) of the data byte is transmitted first, and when DORD is
            written to zero, the most-significant bit (msb) of the data byte is
            transmitted first";
        } DORD[5:5] = 0;

        field {
            desc = "Setting this bit enables the SPI module. This bit must be
            set to enable any SPI operations";
        } ENABLE[6:6] = 0;

        field {
            desc = "When this bit is set, the SPI speed (SCK frequency) will be
            doubled in master mode";
        } CLK2X[7:7] = 0;
    } CTRL;

    reg {
        name = "Interrupt Control";

        field {
            desc = "These bits enable the SPI interrupt and select the interrupt level";
        } INTLVL[1:0] = 0;
    } INTCTRL;

    reg {
        field {
            sw=r; hw=rw; we;
        } WRCOL[6:6] = 0;

        field {
            sw=r; hw=rw; we;
        } IF[7:7] = 0;
    } STATUS;

    reg {
        desc = "The DATA register is used for sending and receiving data.
        Writing to the register initiates the data transmission, and the byte
        written to the register will be shifted out on the SPI output line.
        Reading the register causes the shift register receive buffer to be read,
        returning the last byte successfully received";

        field {
            sw=w; hw=r;
        } WDATA[7:0];

        field {
            sw=r; hw=w;
        } RDATA[7:0];

    } DATA;

    reg {
        desc = "The DATA register is used for sending and receiving data.
        Writing to the register initiates the data transmission, and the byte
        written to the register will be shifted out on the SPI output line.
        Reading the register causes the shift register receive buffer to be read,
        returning the last byte successfully received";

        field {
            sw=w; hw=r;
        } WDATA[7:0];

        field {
            sw=r; hw=w;
        } RDATA[7:0];

    } DATA2;

    reg {
        desc = "The DATA register is used for sending and receiving data.
        Writing to the register initiates the data transmission, and the byte
        written to the register will be shifted out on the SPI output line.
        Reading the register causes the shift register receive buffer to be read,
        returning the last byte successfully received";

        field {
            sw=w; hw=r;
        } WDATA[7:0];

        field {
            sw=r; hw=w;
        } RDATA[7:0];

    } DATA3;

    reg {
        desc = "The DATA register is used for sending and receiving data.
        Writing to the register initiates the data transmission, and the byte
        written to the register will be shifted out on the SPI output line.
        Reading the register causes the shift register receive buffer to be read,
        returning the last byte successfully received";

        field {
            sw=w; hw=r;
        } WDATA[7:0];

        field {
            sw=r; hw=w;
        } RDATA[7:0];

    } DATA4;

    reg {
        desc = "The DATA register is used for sending and receiving data.
        Writing to the register initiates the data transmission, and the byte
        written to the register will be shifted out on the SPI output line.
        Reading the register causes the shift register receive buffer to be read,
        returning the last byte successfully received";

        field {
            sw=w; hw=r;
        } WDATA[7:0];

        field {
            sw=r; hw=w;
        } RDATA[7:0];

    } DATA5;

    reg {
        desc = "The DATA register is used for sending and receiving data.
        Writing to the register initiates the data transmission, and the byte
        written to the register will be shifted out on the SPI output line.
        Reading the register causes the shift register receive buffer to be read,
        returning the last byte successfully received";

        field {
            sw=w; hw=r;
        } WDATA[7:0];

        field {
            sw=r; hw=w;
        } RDATA[7:0];

    } DATA6;

    reg {
        desc = "The DATA register is used for sending and receiving data.
        Writing to the register initiates the data transmission, and the byte
        written to the register will be shifted out on the SPI output line.
        Reading the register causes the shift register receive buffer to be read,
        returning the last byte successfully received";

        field {
            sw=w; hw=r;
        } WDATA[7:0];

        field {
            sw=r; hw=w;
        } RDATA[7:0];

    } DATA7;

    reg {
        desc = "The DATA register is used for sending and receiving data.
        Writing to the register initiates the data transmission, and the byte
        written to the register will be shifted out on the SPI output line.
        Reading the register causes the shift register receive buffer to be read,
        returning the last byte successfully received";

        field {
            sw=w; hw=r;
        } WDATA[7:0];

        field {
            sw=r; hw=w;
        } RDATA[7:0];

    } DATA8;

    reg {
        desc = "The DATA register is used for sending and receiving data.
        Writing to the register initiates the data transmission, and the byte
        written to the register will be shifted out on the SPI output line.
        Reading the register causes the shift register receive buffer to be read,
        returning the last byte successfully received";

        field {
            sw=w; hw=r;
        } WDATA[7:0];

        field {
            sw=r; hw=w;
        } RDATA[7:0];

    } DATA9;

    reg {
        desc = "The DATA register is used for sending and receiving data.
        Writing to the register initiates the data transmission, and the byte
        written to the register will be shifted out on the SPI output line.
        Reading the register causes the shift register receive buffer to be read,
        returning the last byte successfully received";

        field {
            sw=w; hw=r;
        } WDATA[7:0];

        field {
            sw=r; hw=w;
        } RDATA[7:0];

    } DATA10;

    reg {
        desc = "The DATA register is used for sending and receiving data.
        Writing to the register initiates the data transmission, and the byte
        written to the register will be shifted out on the SPI output line.
        Reading the register causes the shift register receive buffer to be read,
        returning the last byte successfully received";

        field {
            sw=w; hw=r;
        } WDATA[7:0];

        field {
            sw=r; hw=w;
        } RDATA[7:0];

    } DATA11;

    reg {
        desc = "The DATA register is used for sending and receiving data.
        Writing to the register initiates the data transmission, and the byte
        written to the register will be shifted out on the SPI output line.
        Reading the register causes the shift register receive buffer to be read,
        returning the last byte successfully received";

        field {
            sw=w; hw=r;
        } WDATA[7:0];

        field {
            sw=r; hw=w;
        } RDATA[7:0];

    } DATA12;

    reg {
        desc = "The DATA register is used for sending and receiving data.
        Writing to the register initiates the data transmission, and the byte
        written to the register will be shifted out on the SPI output line.
        Reading the register causes the shift register receive buffer to be read,
        returning the last byte successfully received";

        field {
            sw=w; hw=r;
        } WDATA[7:0];

        field {
            sw=r; hw=w;
        } RDATA[7:0];

    } DATA13;

    reg {
        desc = "The DATA register is used for sending and receiving data.
        Writing to the register initiates the data transmission, and the byte
        written to the register will be shifted out on the SPI output line.
        Reading the register causes the shift register receive buffer to be read,
        returning the last byte successfully received";

        field {
            sw=w; hw=r;
        } WDATA[7:0];

        field {
            sw=r; hw=w;
        } RDATA[7:0];

    } DATA14;

    reg {
        desc = "The DATA register is used for sending and receiving data.
        Writing to the register initiates the data transmission, and the byte
        written to the register will be shifted out on the SPI output line.
        Reading the register causes the shift register receive buffer to be read,
        returning the last byte successfully received";

        field {
            sw=w; hw=r;
        } WDATA[7:0];

        field {
            sw=r; hw=w;
        } RDATA[7:0];

    } DATA15;

    reg {
        desc = "The DATA register is used for sending and receiving data.
        Writing to the register initiates the data transmission, and the byte
        written to the register will be shifted out on the SPI output line.
        Reading the register causes the shift register receive buffer to be read,
        returning the last byte successfully received";

        field {
            sw=w; hw=r;
        } WDATA[7:0];

        field {
            sw=r; hw=w;
        } RDATA[7:0];

    } DATA16;

    reg {
        desc = "The DATA register is used for sending and receiving data.
        Writing to the register initiates the data transmission, and the byte
        written to the register will be shifted out on the SPI output line.
        Reading the register causes the shift register receive buffer to be read,
        returning the last byte successfully received";

        field {
            sw=w; hw=r;
        } WDATA[7:0];

        field {
            sw=r; hw=w;
        } RDATA[7:0];

    } DATA17;

    reg {
        desc = "The DATA register is used for sending and receiving data.
        Writing to the register initiates the data transmission, and the byte
        written to the register will be shifted out on the SPI output line.
        Reading the register causes the shift register receive buffer to be read,
        returning the last byte successfully received";

        field {
            sw=w; hw=r;
        } WDATA[7:0];

        field {
            sw=r; hw=w;
        } RDATA[7:0];

        field {
            sw=r; hw=w;
        } RDATA2[2];

        field {
            sw=r; hw=w;
        } RDATA3[2];

        field {
            sw=r; hw=w;
        } RDATA4[2];

        field {
            sw=r; hw=w;
        } RDATA5[2];

        field {
            sw=r; hw=w;
        } RDATA6[2];

        field {
            sw=r; hw=w;
        } RDATA7[2];

        field {
            sw=r; hw=w;
        } RDATA8[2];

        field {
            sw=r; hw=w;
        } RDATA9[2];

        field {
            sw=r; hw=w;
        } RDATA10[2];

        field {
            sw=r; hw=w;
        } RDATA11[2];

        field {
            sw=r; hw=w;
        } RDATA12[2];

    } DATA18;
};
