
addrmap atxmega_spi {
    name = "ATXMEGA SPI controller";

    default regwidth = 32;
    default sw = rw;
    default hw = r;

    reg {
        desc = "Dummy register";

        field {
            sw=rw; hw=r;
        } dummy_field0[7:0];

        field {
            sw=rw; hw=r;
        } dummy_field1[15:8];

    } dummy_reg0;

    reg {
        desc = "Dummy register";

        field {
            sw=rw; hw=r;
        } dummy_field0[7:0];

        field {
            sw=rw; hw=r;
        } dummy_field1[15:8];

    } dummy_reg1;

    reg {
        desc = "Dummy register";

        field {
            sw=rw; hw=r;
        } dummy_field0[7:0];

        field {
            sw=rw; hw=r;
        } dummy_field1[15:8];

    } dummy_reg2;

    reg {
        desc = "Dummy register";

        field {
            sw=rw; hw=r;
        } dummy_field0[7:0];

        field {
            sw=rw; hw=r;
        } dummy_field1[15:8];

    } dummy_reg3;

    reg {
        desc = "Dummy register";

        field {
            sw=rw; hw=r;
        } dummy_field0[7:0];

        field {
            sw=rw; hw=r;
        } dummy_field1[15:8];

    } dummy_reg4;

    reg {
        desc = "Dummy register";

        field {
            sw=rw; hw=r;
        } dummy_field0[7:0];

        field {
            sw=rw; hw=r;
        } dummy_field1[15:8];

    } dummy_reg5;

    reg {
        desc = "Dummy register";

        field {
            sw=rw; hw=r;
        } dummy_field0[7:0];

        field {
            sw=rw; hw=r;
        } dummy_field1[15:8];

    } dummy_reg6;

    reg {
        desc = "Dummy register";

        field {
            sw=rw; hw=r;
        } dummy_field0[7:0];

        field {
            sw=rw; hw=r;
        } dummy_field1[15:8];

    } dummy_reg7;

    reg {
        desc = "Dummy register";

        field {
            sw=rw; hw=r;
        } dummy_field0[7:0];

        field {
            sw=rw; hw=r;
        } dummy_field1[15:8];

    } dummy_reg8;

    reg {
        desc = "Dummy register";

        field {
            sw=rw; hw=r;
        } dummy_field0[7:0];

        field {
            sw=rw; hw=r;
        } dummy_field1[15:8];

    } dummy_reg9;

    reg {
        desc = "Dummy register";

        field {
            sw=rw; hw=r;
        } dummy_field0[7:0];

        field {
            sw=rw; hw=r;
        } dummy_field1[15:8];

    } dummy_reg10;

    reg {
        desc = "Dummy register";

        field {
            sw=rw; hw=r;
        } dummy_field0[7:0];

        field {
            sw=rw; hw=r;
        } dummy_field1[15:8];

    } dummy_reg11;

    reg {
        desc = "Dummy register";

        field {
            sw=rw; hw=r;
        } dummy_field0[7:0];

        field {
            sw=rw; hw=r;
        } dummy_field1[15:8];

    } dummy_reg12;

    reg {
        desc = "Dummy register";

        field {
            sw=rw; hw=r;
        } dummy_field0[7:0];

        field {
            sw=rw; hw=r;
        } dummy_field1[15:8];

    } dummy_reg13;

    reg {
        desc = "Dummy register";

        field {
            sw=rw; hw=r;
        } dummy_field0[7:0];

        field {
            sw=rw; hw=r;
        } dummy_field1[15:8];

    } dummy_reg14;

    reg {
        desc = "Dummy register";

        field {
            sw=rw; hw=r;
        } dummy_field0[7:0];

        field {
            sw=rw; hw=r;
        } dummy_field1[15:8];

    } dummy_reg15;

    reg {
        desc = "Dummy register";

        field {
            sw=rw; hw=r;
        } dummy_field0[7:0];

        field {
            sw=rw; hw=r;
        } dummy_field1[15:8];

    } dummy_reg16;

    reg {
        desc = "Dummy register";

        field {
            sw=rw; hw=r;
        } dummy_field0[7:0];

        field {
            sw=rw; hw=r;
        } dummy_field1[15:8];

    } dummy_reg17;

    reg {
        desc = "Dummy register";

        field {
            sw=rw; hw=r;
        } dummy_field0[7:0];

        field {
            sw=rw; hw=r;
        } dummy_field1[15:8];

    } dummy_reg18;

    reg {
        desc = "Dummy register";

        field {
            sw=rw; hw=r;
        } dummy_field0[7:0];

        field {
            sw=rw; hw=r;
        } dummy_field1[15:8];

    } dummy_reg19;
};
